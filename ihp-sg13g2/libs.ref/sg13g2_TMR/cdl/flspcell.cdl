************************************************************************
*
* Copyright 2023 IHP PDK Authors
*
* Licensed under the Apache License, Version 2.0 (the "License");
* you may not use this file except in compliance with the License.
* You may obtain a copy of the License at
*
*    https://www.apache.org/licenses/LICENSE-2.0
*
* Unless required by applicable law or agreed to in writing, software
* distributed under the License is distributed on an "AS IS" BASIS,
* WITHOUT WARRANTIES OR CONDITIONS OF ANY KIND, either express or implied.
* See the License for the specific language governing permissions and
* limitations under the License.
*
************************************************************************

************************************************************************
* Library Name: flspcell
* Cell Name:    sg13g2_dfrbpq1arx_1
* View Name:    schematic
************************************************************************

.SUBCKT sg13g2_dfrbpq1arx_1 Q CLK D RESET_B VDD VSS
*.PININFO CLK:I D:I RESET_B:I Q:O VDD:B VSS:B
MN73 net764 q0 net780 VSS sg13_lv_nmos m=1 w=640.00n l=130.00n ng=1
MN75 vot01 net764 VSS VSS sg13_lv_nmos m=1 w=740.00n l=130.00n ng=1
MN74 net780 q1 VSS VSS sg13_lv_nmos m=1 w=640.00n l=130.00n ng=1
MN57 net739 q2 VSS VSS sg13_lv_nmos m=1 w=640.00n l=130.00n ng=1
MN59 vot02 net728 VSS VSS sg13_lv_nmos m=1 w=740.00n l=130.00n ng=1
MN56 net728 q0 net739 VSS sg13_lv_nmos m=1 w=640.00n l=130.00n ng=1
MN68 net690 q2 VSS VSS sg13_lv_nmos m=1 w=640.00n l=130.00n ng=1
MN69 net614 vot12 VSS VSS sg13_lv_nmos m=1 w=550.00n l=130.00n ng=1
MN39 Db_2 clkneg_2 net43 VSS sg13_lv_nmos m=1 w=420.00n l=130.00n ng=1
MN25 Db_2 Ddly2b net50 VSS sg13_lv_nmos m=1 w=420.00n l=130.00n ng=1
MN29 clkneg_2 CLK VSS VSS sg13_lv_nmos m=1 w=740.00n l=130.00n ng=1
MN35 clkpos_2 clkneg_2 VSS VSS sg13_lv_nmos m=1 w=740.00n l=130.00n ng=1
MN26 net50 RESET_B VSS VSS sg13_lv_nmos m=1 w=420.00n l=130.00n ng=1
MN52 net38 clkpos_2 net33 VSS sg13_lv_nmos m=1 w=740.00n l=130.00n ng=1
MN53 net33 clkneg_2 net41 VSS sg13_lv_nmos m=1 w=420.00n l=130.00n ng=1
MN60 net39 net33 net42 VSS sg13_lv_nmos m=1 w=420.00n l=130.00n ng=1
MN40 net43 clkpos_2 net47 VSS sg13_lv_nmos m=1 w=420.00n l=130.00n ng=1
MN54 net41 net39 VSS VSS sg13_lv_nmos m=1 w=420.00n l=130.00n ng=1
MN61 net42 RESET_B VSS VSS sg13_lv_nmos m=1 w=420.00n l=130.00n ng=1
MN64 net2 net33 VSS VSS sg13_lv_nmos m=1 w=740.00n l=130.00n ng=1
MN41 net47 net38 net48 VSS sg13_lv_nmos m=1 w=420.00n l=130.00n ng=1
MN48 net38 net43 VSS VSS sg13_lv_nmos m=1 w=740.00n l=130.00n ng=1
MN70 q2 net34 VSS VSS sg13_lv_nmos m=1 w=740.00n l=130.00n ng=1
MN66 net34 net33 VSS VSS sg13_lv_nmos m=1 w=740.00n l=130.00n ng=1
MN42 net48 RESET_B VSS VSS sg13_lv_nmos m=1 w=420.00n l=130.00n ng=1
MN21 Ddly2b net35 VSS VSS sg13_lv_nmos m=1 w=740.00n l=130.00n ng=1
MN17 net35 net55 VSS VSS sg13_lv_nmos m=1 w=420.00n l=180.00n ng=1
MN13 net55 net56 VSS VSS sg13_lv_nmos m=1 w=420.00n l=180.00n ng=1
MN11 net56 Ddly2a VSS VSS sg13_lv_nmos m=1 w=420.00n l=130.00n ng=1
MN8 Ddly2a net32 VSS VSS sg13_lv_nmos m=1 w=740.00n l=130.00n ng=1
MN6 net32 net31 VSS VSS sg13_lv_nmos m=1 w=420.00n l=180.00n ng=1
MN2 net31 net30 VSS VSS sg13_lv_nmos m=1 w=420.00n l=180.00n ng=1
MN14 Db_0 clkneg_0 net20 VSS sg13_lv_nmos m=1 w=420.00n l=130.00n ng=1
MN72 vot12 net674 VSS VSS sg13_lv_nmos m=1 w=740.00n l=130.00n ng=1
MN27 net21 clkpos_0 net18 VSS sg13_lv_nmos m=1 w=740.00n l=130.00n ng=1
MN3 Db_0 D net23 VSS sg13_lv_nmos m=1 w=420.00n l=130.00n ng=1
MN30 net18 clkneg_0 net26 VSS sg13_lv_nmos m=1 w=420.00n l=130.00n ng=1
MN36 net25 net18 net24 VSS sg13_lv_nmos m=1 w=420.00n l=130.00n ng=1
MN18 net20 clkpos_0 net22 VSS sg13_lv_nmos m=1 w=420.00n l=130.00n ng=1
MN67 net674 q1 net690 VSS sg13_lv_nmos m=1 w=640.00n l=130.00n ng=1
MN9 clkneg_0 CLK VSS VSS sg13_lv_nmos m=1 w=740.00n l=130.00n ng=1
MN12 clkpos_0 clkneg_0 VSS VSS sg13_lv_nmos m=1 w=740.00n l=130.00n ng=1
MN31 net26 net25 VSS VSS sg13_lv_nmos m=1 w=420.00n l=130.00n ng=1
MN37 net24 RESET_B VSS VSS sg13_lv_nmos m=1 w=420.00n l=130.00n ng=1
MN44 net1 net18 VSS VSS sg13_lv_nmos m=1 w=740.00n l=130.00n ng=1
MN4 net23 RESET_B VSS VSS sg13_lv_nmos m=1 w=420.00n l=130.00n ng=1
MN19 net22 net21 net16 VSS sg13_lv_nmos m=1 w=420.00n l=130.00n ng=1
MN23 net21 net20 VSS VSS sg13_lv_nmos m=1 w=740.00n l=130.00n ng=1
MN49 q0 net19 VSS VSS sg13_lv_nmos m=1 w=740.00n l=130.00n ng=1
MN28 Db_1 clkneg_1 net7 VSS sg13_lv_nmos m=1 w=420.00n l=130.00n ng=1
MN65 net614 vot02 VSS VSS sg13_lv_nmos m=1 w=550.00n l=130.00n ng=1
MN43 net8 clkpos_1 net5 VSS sg13_lv_nmos m=1 w=740.00n l=130.00n ng=1
MN15 Db_1 net17 net10 VSS sg13_lv_nmos m=1 w=420.00n l=130.00n ng=1
MN45 net5 clkneg_1 net13 VSS sg13_lv_nmos m=1 w=420.00n l=130.00n ng=1
MN50 net12 net5 net11 VSS sg13_lv_nmos m=1 w=420.00n l=130.00n ng=1
MN32 net7 clkpos_1 net9 VSS sg13_lv_nmos m=1 w=420.00n l=130.00n ng=1
MN63 net614 vot01 VSS VSS sg13_lv_nmos m=1 w=550.00n l=130.00n ng=1
MN22 clkneg_1 CLK VSS VSS sg13_lv_nmos m=1 w=740.00n l=130.00n ng=1
MN24 clkpos_1 clkneg_1 VSS VSS sg13_lv_nmos m=1 w=740.00n l=130.00n ng=1
MN46 net13 net12 VSS VSS sg13_lv_nmos m=1 w=420.00n l=130.00n ng=1
MN51 net11 RESET_B VSS VSS sg13_lv_nmos m=1 w=420.00n l=130.00n ng=1
MN55 net3 net5 VSS VSS sg13_lv_nmos m=1 w=740.00n l=130.00n ng=1
MN16 net10 RESET_B VSS VSS sg13_lv_nmos m=1 w=420.00n l=130.00n ng=1
MN33 net9 net8 net4 VSS sg13_lv_nmos m=1 w=420.00n l=130.00n ng=1
MN38 net8 net7 VSS VSS sg13_lv_nmos m=1 w=740.00n l=130.00n ng=1
MN62 q1 net6 VSS VSS sg13_lv_nmos m=1 w=740.00n l=130.00n ng=1
MN58 net6 net5 VSS VSS sg13_lv_nmos m=1 w=740.00n l=130.00n ng=1
MN71 Q net614 VSS VSS sg13_lv_nmos m=1 w=740.00n l=130.00n ng=1
MN34 net4 RESET_B VSS VSS sg13_lv_nmos m=1 w=420.00n l=130.00n ng=1
MN47 net19 net18 VSS VSS sg13_lv_nmos m=1 w=740.00n l=130.00n ng=1
MN20 net16 RESET_B VSS VSS sg13_lv_nmos m=1 w=420.00n l=130.00n ng=1
MN0 net30 D VSS VSS sg13_lv_nmos m=1 w=420.00n l=130.00n ng=1
MN10 net17 net46 VSS VSS sg13_lv_nmos m=1 w=740.00n l=130.00n ng=1
MN7 net46 net45 VSS VSS sg13_lv_nmos m=1 w=420.00n l=180.00n ng=1
MN5 net45 net44 VSS VSS sg13_lv_nmos m=1 w=420.00n l=180.00n ng=1
MN1 net44 D VSS VSS sg13_lv_nmos m=1 w=420.00n l=130.00n ng=1
MP73 net764 q1 VDD VDD sg13_lv_pmos m=1 w=840.00n l=130.00n ng=1
MP74 net764 q0 VDD VDD sg13_lv_pmos m=1 w=840.00n l=130.00n ng=1
MP75 vot01 net764 VDD VDD sg13_lv_pmos m=1 w=1.12u l=130.00n ng=1
MP60 vot02 net728 VDD VDD sg13_lv_pmos m=1 w=1.12u l=130.00n ng=1
MP57 net728 q0 VDD VDD sg13_lv_pmos m=1 w=840.00n l=130.00n ng=1
MP53 net728 q2 VDD VDD sg13_lv_pmos m=1 w=840.00n l=130.00n ng=1
MP64 net674 q2 VDD VDD sg13_lv_pmos m=1 w=840.00n l=130.00n ng=1
MP66 net674 q1 VDD VDD sg13_lv_pmos m=1 w=840.00n l=130.00n ng=1
MP67 net639 vot01 VDD VDD sg13_lv_pmos m=1 w=1.000u l=130.00n ng=1
MP71 Q net614 VDD VDD sg13_lv_pmos m=1 w=1.12u l=130.00n ng=1
MP68 net27 vot02 net639 VDD sg13_lv_pmos m=1 w=1.000u l=130.00n ng=1
MP69 net614 vot12 net27 VDD sg13_lv_pmos m=1 w=1.000u l=130.00n ng=1
MP38 Db_2 clkpos_2 net43 VDD sg13_lv_pmos m=1 w=420.00n l=130.00n ng=1
MP24 Db_2 RESET_B VDD VDD sg13_lv_pmos m=1 w=420.00n l=130.00n ng=1
MP26 Db_2 Ddly2b VDD VDD sg13_lv_pmos m=1 w=420.00n l=130.00n ng=1
MP29 clkneg_2 CLK VDD VDD sg13_lv_pmos m=1 w=1.12u l=130.00n ng=1
MP34 clkpos_2 clkneg_2 VDD VDD sg13_lv_pmos m=1 w=1.12u l=130.00n ng=1
MP72 vot12 net674 VDD VDD sg13_lv_pmos m=1 w=1.12u l=130.00n ng=1
MP40 net49 net38 VDD VDD sg13_lv_pmos m=1 w=420.00n l=130.00n ng=1
MP54 net40 net39 VDD VDD sg13_lv_pmos m=1 w=420.00n l=130.00n ng=1
MP44 net43 RESET_B VDD VDD sg13_lv_pmos m=1 w=420.00n l=130.00n ng=1
MP51 net38 clkneg_2 net33 VDD sg13_lv_pmos m=1 w=1.000u l=130.00n ng=1
MP55 net33 clkpos_2 net40 VDD sg13_lv_pmos m=1 w=420.00n l=130.00n ng=1
MP58 net39 net33 VDD VDD sg13_lv_pmos m=1 w=420.00n l=130.00n ng=1
MP61 net39 RESET_B VDD VDD sg13_lv_pmos m=1 w=420.00n l=130.00n ng=1
MP63 net2 net33 VDD VDD sg13_lv_pmos m=1 w=1.12u l=130.00n ng=1
MP41 net43 clkneg_2 net49 VDD sg13_lv_pmos m=1 w=420.00n l=130.00n ng=1
MP48 net38 net43 VDD VDD sg13_lv_pmos m=1 w=1.000u l=130.00n ng=1
MP70 q2 net34 VDD VDD sg13_lv_pmos m=1 w=1.12u l=130.00n ng=1
MP65 net34 net33 VDD VDD sg13_lv_pmos m=1 w=1.12u l=130.00n ng=1
MP20 Ddly2b net35 VDD VDD sg13_lv_pmos m=1 w=1.12u l=130.00n ng=1
MP16 net35 net55 VDD VDD sg13_lv_pmos m=1 w=1.000u l=250.00n ng=1
MP13 net55 net56 VDD VDD sg13_lv_pmos m=1 w=1.000u l=250.00n ng=1
MP11 net56 Ddly2a VDD VDD sg13_lv_pmos m=1 w=420.00n l=130.00n ng=1
MP8 Ddly2a net32 VDD VDD sg13_lv_pmos m=1 w=1.12u l=130.00n ng=1
MP5 net32 net31 VDD VDD sg13_lv_pmos m=1 w=1.000u l=250.00n ng=1
MP2 net31 net30 VDD VDD sg13_lv_pmos m=1 w=1.000u l=250.00n ng=1
MP0 net30 D VDD VDD sg13_lv_pmos m=1 w=420.00n l=130.00n ng=1
MP17 net28 net21 VDD VDD sg13_lv_pmos m=1 w=420.00n l=130.00n ng=1
MP30 net29 net25 VDD VDD sg13_lv_pmos m=1 w=420.00n l=130.00n ng=1
MP21 net20 RESET_B VDD VDD sg13_lv_pmos m=1 w=420.00n l=130.00n ng=1
MP15 Db_0 clkpos_0 net20 VDD sg13_lv_pmos m=1 w=420.00n l=130.00n ng=1
MP27 net21 clkneg_0 net18 VDD sg13_lv_pmos m=1 w=1.000u l=130.00n ng=1
MP31 net18 clkpos_0 net29 VDD sg13_lv_pmos m=1 w=420.00n l=130.00n ng=1
MP35 net25 net18 VDD VDD sg13_lv_pmos m=1 w=420.00n l=130.00n ng=1
MP39 net25 RESET_B VDD VDD sg13_lv_pmos m=1 w=420.00n l=130.00n ng=1
MP43 net1 net18 VDD VDD sg13_lv_pmos m=1 w=1.12u l=130.00n ng=1
MP3 Db_0 RESET_B VDD VDD sg13_lv_pmos m=1 w=420.00n l=130.00n ng=1
MP6 Db_0 D VDD VDD sg13_lv_pmos m=1 w=420.00n l=130.00n ng=1
MP18 net20 clkneg_0 net28 VDD sg13_lv_pmos m=1 w=420.00n l=130.00n ng=1
MP9 clkneg_0 CLK VDD VDD sg13_lv_pmos m=1 w=1.12u l=130.00n ng=1
MP12 clkpos_0 clkneg_0 VDD VDD sg13_lv_pmos m=1 w=1.12u l=130.00n ng=1
MP23 net21 net20 VDD VDD sg13_lv_pmos m=1 w=1.000u l=130.00n ng=1
MP49 q0 net19 VDD VDD sg13_lv_pmos m=1 w=1.12u l=130.00n ng=1
MP47 net19 net18 VDD VDD sg13_lv_pmos m=1 w=1.12u l=130.00n ng=1
MP32 net14 net8 VDD VDD sg13_lv_pmos m=1 w=420.00n l=130.00n ng=1
MP45 net15 net12 VDD VDD sg13_lv_pmos m=1 w=420.00n l=130.00n ng=1
MP36 net7 RESET_B VDD VDD sg13_lv_pmos m=1 w=420.00n l=130.00n ng=1
MP28 Db_1 clkpos_1 net7 VDD sg13_lv_pmos m=1 w=420.00n l=130.00n ng=1
MP42 net8 clkneg_1 net5 VDD sg13_lv_pmos m=1 w=1.000u l=130.00n ng=1
MP46 net5 clkpos_1 net15 VDD sg13_lv_pmos m=1 w=420.00n l=130.00n ng=1
MP50 net12 net5 VDD VDD sg13_lv_pmos m=1 w=420.00n l=130.00n ng=1
MP52 net12 RESET_B VDD VDD sg13_lv_pmos m=1 w=420.00n l=130.00n ng=1
MP56 net3 net5 VDD VDD sg13_lv_pmos m=1 w=1.12u l=130.00n ng=1
MP14 Db_1 RESET_B VDD VDD sg13_lv_pmos m=1 w=420.00n l=130.00n ng=1
MP19 Db_1 net17 VDD VDD sg13_lv_pmos m=1 w=420.00n l=130.00n ng=1
MP33 net7 clkneg_1 net14 VDD sg13_lv_pmos m=1 w=420.00n l=130.00n ng=1
MP22 clkneg_1 CLK VDD VDD sg13_lv_pmos m=1 w=1.12u l=130.00n ng=1
MP25 clkpos_1 clkneg_1 VDD VDD sg13_lv_pmos m=1 w=1.12u l=130.00n ng=1
MP37 net8 net7 VDD VDD sg13_lv_pmos m=1 w=1.000u l=130.00n ng=1
MP62 q1 net6 VDD VDD sg13_lv_pmos m=1 w=1.12u l=130.00n ng=1
MP59 net6 net5 VDD VDD sg13_lv_pmos m=1 w=1.12u l=130.00n ng=1
MP10 net17 net46 VDD VDD sg13_lv_pmos m=1 w=1.12u l=130.00n ng=1
MP7 net46 net45 VDD VDD sg13_lv_pmos m=1 w=1.000u l=250.00n ng=1
MP4 net45 net44 VDD VDD sg13_lv_pmos m=1 w=1.000u l=250.00n ng=1
MP1 net44 D VDD VDD sg13_lv_pmos m=1 w=420.00n l=130.00n ng=1
.ENDS
